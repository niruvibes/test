ADE simulation setup
Run mode: Monte Carlo Sampling
Tests:
  lib4602:tb_opamp4602:1: lib4602/tb_opamp4602/schematic, simulator spectre
    Variables: cc = 1.0p; rc = 1
Monte Carlo Sampling options: mcnumpoints=200, yeyistostart=3.0, mcSigmaTarget=3, sssnumpoints=7000, yeexpectedyield=3, mcmethod=all, wcdinitialpoints=200, yeiterations=10, yeusehistorymc=0, yeuseautomcsamples=1, yecreatecorners=0, haveyeyieldtostart=1, yeusevarreduction=1
