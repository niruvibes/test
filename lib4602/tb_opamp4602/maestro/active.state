ADE simulation setup
Test lib4602:tb_opamp4602:1: lib4602/tb_opamp4602/schematic, simulator spectre
  Models: /usr/local/cadence/FreePDK45/ncsu_basekit/models/hspice/hspice_stat.include
  Variables: cc = 1.0p; rc = 1
  Temperature: 27
  Analysis dc: sweep /V2.dc start=1.64 stop=1.66 step=0.001
  Signals: /Vout, /Vinp
Run mode: Monte Carlo Sampling
Monte Carlo Sampling options: mcnumpoints=200, yeyistostart=3.0, mcSigmaTarget=3, sssnumpoints=7000, yeexpectedyield=3, mcmethod=all, wcdinitialpoints=200, yeiterations=10, yeusehistorymc=0, yeuseautomcsamples=1, yecreatecorners=0, haveyeyieldtostart=1, yeusevarreduction=1
