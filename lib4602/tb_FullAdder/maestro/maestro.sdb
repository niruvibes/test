ADE simulation setup
Run mode: Single Run, Sweeps and Corners
Tests:
  lib4602:tb_FullAdder:1: lib4602/tb_FullAdder/schematic, simulator spectre
    Outputs: /q; /Ci; /Sboost
