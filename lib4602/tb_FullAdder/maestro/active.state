ADE simulation setup
Test lib4602:tb_FullAdder:1: lib4602/tb_FullAdder/schematic, simulator spectre
  Temperature: 27
  Analysis tran: stop=24n errpreset=moderate
  Signals: /net4, /net5, /net6, /net9, /net10
Run mode: Single Run, Sweeps and Corners
