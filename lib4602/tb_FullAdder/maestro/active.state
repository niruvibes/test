ADE simulation setup
Test lib4602:tb_FullAdder:1: lib4602/tb_FullAdder/schematic, simulator spectre
  Models: /usr/local/cadence/FreePDK45/ncsu_basekit/models/hspice/hspice_ff.include
  Temperature: 27
  Analysis tran: stop=24n errpreset=moderate
  Signals: /A, /B, /Ci, /Co, /Sboost
Run mode: Single Run, Sweeps and Corners
