ADE simulation setup
Run mode: Single Run, Sweeps and Corners
Tests:
  lib4602:tb_nor4602:1: lib4602/tb_nor4602/schematic, simulator spectre
