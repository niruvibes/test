ADE simulation setup
Test lib4602:tb_nor4602:1: lib4602/tb_nor4602/schematic, simulator spectre
  Models: /usr/local/cadence/FreePDK45/ncsu_basekit/models/hspice/hspice_stat.include
  Temperature: 27
  Analysis tran: stop=2n
  Analysis dc: sweep /V1.dc start=0 stop=0.9
  Analysis ac: start=100 stop=100G
  Signals: /A, /B, /Y, /V0/MINUS (terminal), /V0/PLUS (terminal)
Run mode: Single Run, Sweeps and Corners
