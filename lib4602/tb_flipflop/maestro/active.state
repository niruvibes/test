ADE simulation setup
Test lib4602:tb_flipflop:1: lib4602/tb_flipflop/schematic, simulator spectre
  Models: /usr/local/cadence/FreePDK45/ncsu_basekit/models/hspice/hspice_stat.include
  Variables: nmosType = NMOS_VTG; pmosType = PMOS_VTG; delta = 0
  Temperature: 27
  Analysis tran: stop=8n
  Signals: /Q, /notQ, /D, /Ck
Run mode: Single Run, Sweeps and Corners
Setup values for test lib4602:tb_flipflop:1: delta = -50p:5p:50p
