ADE simulation setup
Run mode: Single Run, Sweeps and Corners
Tests:
  lib4602:tb_flipflop:1: lib4602/tb_flipflop/schematic, simulator spectre
    Variables: nmosType = NMOS_VTG; pmosType = PMOS_VTG; delta = -50p:5p:50p
